ADE simulation setup
Run mode: Single Run, Sweeps and Corners
Tests:
  VLSI_proj_tb_32x32sram_1: VLSI_proj/tb_32x32sram/schematic, simulator hspiceD
