ADE simulation setup
Test VLSI_proj_tb_32x32sram_1: VLSI_proj/tb_32x32sram/schematic, simulator hspiceD
  Models: /cs/student/mingyi_huang/Desktop/ncsu45_cp/hspice_nom.include
  Initial conditions: /I0/I1/I3/net1 = 1; /I0/I1/I3/net2 = 0; /net1<0> = 1; /net2<0> = 0; /net3<0> = 0
  Analysis tran: start=0 stop=50n step=1p
  Signals: /net20<0>, /wr_en, /ck, /addr_en, /pchb, /net1<0>, /net2<0>, /sa_en, /net3<0>, /net17<0>, /net17<1>, /net17<3>, /net17<2>, /net17<4>, /I0/I1/I3/net2, /I0/I1/I3/net1, /net9<0>, /net9<1>, /net9<2>, /net9<3>, /net9<4>, /net9<5>, /net9<6>, /net9<7>, /net9<8>, /net9<9>, /net9<10>, /net9<11>, /net9<12>, /net9<13>, /net9<14>, /net9<15>, /net9<16>, /net9<17>, /net9<18>, /net9<19>, /net9<20>, /net9<21>, /net9<22>, /net9<23>, /net9<24>, /net9<25>, /net9<26>, /net9<27>, /net9<28>, /net9<29>, /net9<30>, /net9<31>
Run mode: Single Run, Sweeps and Corners
