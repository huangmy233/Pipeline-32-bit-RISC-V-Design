ADE simulation setup
Test project_NAND5_RY_test_1: project/NAND5_RY_test/schematic, simulator hspiceD
  Models: /cs/student/ruiyang321/Desktop/ncsu45_cp/hspice_nom.include
  Analysis tran: start=0 stop=15u step=0.1u
  Signals: /net5, /net4, /net3, /net2, /net1, /net6
Run mode: Single Run, Sweeps and Corners
