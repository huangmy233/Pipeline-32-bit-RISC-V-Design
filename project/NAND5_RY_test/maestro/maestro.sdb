ADE simulation setup
Run mode: Single Run, Sweeps and Corners
Tests:
  project_NAND5_RY_test_1: project/NAND5_RY_test/schematic, simulator hspiceD
