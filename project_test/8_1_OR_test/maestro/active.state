ADE simulation setup
Test project_test_8_1_OR_test_1: project_test/8_1_OR_test/schematic, simulator hspiceD
  Models: /cs/student/ruiyang321/Desktop/ncsu45_cp/hspice_nom.include
  Analysis tran: stop=320n step=2n
  Signals: /OUT, /s0, /s1, /s2, /s3, /s4, /s5, /s6, /s7
Run mode: Single Run, Sweeps and Corners
