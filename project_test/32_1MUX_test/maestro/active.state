ADE simulation setup
Test project_test_32_1MUX_test_1: project_test/32_1MUX_test/schematic, simulator hspiceD
  Models: /cs/student/ruiyang321/Desktop/ncsu45_cp/hspice_nom.include
  Analysis tran: start=0 stop=160n step=2n
  Signals: /IN<0:31>, /OUT, /s<4:0>
Run mode: Single Run, Sweeps and Corners
