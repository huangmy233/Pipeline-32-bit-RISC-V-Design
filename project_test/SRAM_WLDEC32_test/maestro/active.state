ADE simulation setup
Test project_test_SRAM_WLDEC32_test_1: project_test/SRAM_WLDEC32_test/schematic, simulator hspiceD
  Models: /cs/student/ruiyang321/Desktop/ncsu45_cp/hspice_nom.include
  Variables: per = 20n; vddi = 1
  Analysis tran: start=0 stop=400n step=1p
  Signals: /ck, /addr_en, /wl<0:31>, /addr<4>, /addr<3>, /addr<2>, /addr<1>, /addr<0>
Run mode: Single Run, Sweeps and Corners
