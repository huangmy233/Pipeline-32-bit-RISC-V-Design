ADE simulation setup
Run mode: Single Run, Sweeps and Corners
Tests:
  project_test_SRAM_WLDEC32_test_1: project_test/SRAM_WLDEC32_test/schematic, simulator hspiceD
    Variables: per = 20n; vddi = 1
