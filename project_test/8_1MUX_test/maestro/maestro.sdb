ADE simulation setup
Run mode: Single Run, Sweeps and Corners
Tests:
  project_test_8_1MUX_test_1: project_test/8_1MUX_test/schematic, simulator hspiceD
