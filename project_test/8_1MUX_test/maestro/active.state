ADE simulation setup
Test project_test_8_1MUX_test_1: project_test/8_1MUX_test/schematic, simulator hspiceD
  Models: /cs/student/ruiyang321/Desktop/ncsu45_cp/hspice_nom.include
  Analysis tran: start=0 stop=50n step=1n
  Signals: /IN<0:7>, /OUT, /s2, /s1, /s0, /E
Run mode: Single Run, Sweeps and Corners
