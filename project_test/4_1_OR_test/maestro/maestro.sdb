ADE simulation setup
Run mode: Single Run, Sweeps and Corners
Tests:
  project_test_4_1_OR_test_1: project_test/4_1_OR_test/schematic, simulator hspiceD
