ADE simulation setup
Test project_test_4_1_OR_test_1: project_test/4_1_OR_test/schematic, simulator hspiceD
  Models: /cs/student/ruiyang321/Desktop/ncsu45_cp/hspice_nom.include
  Analysis tran: start=0 stop=90n step=2n
  Signals: /s0, /s1, /s2, /s3, /OUT
Run mode: Single Run, Sweeps and Corners
