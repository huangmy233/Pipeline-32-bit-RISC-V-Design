ADE simulation setup
Run mode: Single Run, Sweeps and Corners
Tests:
  project_test_regfile32_test_1: project_test/regfile32_test/schematic, simulator hspiceD
