ADE simulation setup
Test project_test_regfile32_test_1: project_test/regfile32_test/schematic, simulator hspiceD
  Models: /cs/student/ruiyang321/Desktop/ncsu45_cp/hspice_nom.include
  Analysis tran: start=0 stop=100n step=2n
  Signals: /clk, /addr_en, /W, /sA<4:0>, /addr<4:0>, /OUTA<0:31>, /D<0:31>
Run mode: Single Run, Sweeps and Corners
